* C:\users\dominik\Meine Dokumente\DGSSPICE_TEST0.asc
* Generated by LTspice 26.0.1 for Windows.
V1 N001 0 123
R1 N002 N001 1k
R2 N003 N002 1k
R3 0 N002 1k
R4 0 N003 1k
.op
.backanno
.end
