* C:\users\dominik\Meine Dokumente\DGSSPICE_TEST3.asc
* Generated by LTspice 26.0.1 for Windows.
I1 0 N001 3m
R1 N002 N001 5k
R4 0 N002 13k
R2 N002 N003 1k
R8 0 N005 2k
V1 N003 N005 12
R5 N005 N002 1.8k
R3 N004 N003 3k
R6 N004 N005 3k
R7 N006 N004 3k
V2 N006 N005 15
.op
.backanno
.end
