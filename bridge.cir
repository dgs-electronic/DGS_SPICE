* Wheatstone-Bruecke mit Spannungsquelle
V1 1 0 12
R1 1 2 2k
R2 1 3 1k
R3 2 0 1k
R4 3 0 2k
R5 2 3 500
