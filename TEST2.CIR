* C:\users\dominik\Meine Dokumente\DGSSPICE_TEST2.asc
* Generated by LTspice 26.0.1 for Windows.
V1 N001 0 16
R1 N001 0 400
R2 N002 N001 200
R4 N003 0 200
R5 N003 N002 120
R3 0 N002 300
V2 N002 N003 24
.op
.backanno
.end
