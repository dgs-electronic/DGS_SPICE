* C:\users\dominik\Meine Dokumente\DGSSPICE_TEST1.asc
* Generated by LTspice 26.0.1 for Windows.
V1 N001 0 10
R1 N003 N001 1k
R2 0 N003 10k
R3 N003 N002 100
R4 N002 0 200
I1 N002 N003 100m
R5 N002 N001 10
.op
.backanno
.end
